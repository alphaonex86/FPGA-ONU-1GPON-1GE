* SPDX-License-Identifier: CERN-OHL-S-2.0
* BFR380F model: rough Gummel-Poon fit of the public datasheet (hFE 120, fT 14 GHz, Ccb 0.5 pF), not the vendor model
* Discrete burst-mode laser driver, 5 V laser rail, BFR380F current steering
.param ibias=30m imod=30m ui=803.75p
.model bfr NPN(IS=2e-15 BF=120 NF=1 VAF=30 IKF=0.15 RB=4 RE=0.4 RC=2 CJE=1.2p VJE=0.8 MJE=0.4 CJC=0.5p VJC=0.6 MJC=0.35 TF=9p TR=1n XTF=2 ITF=0.1)
.subckt q c b e
Lb b bi 0.4n
Le e ei 0.3n
Lc c ci 0.4n
Q1 ci bi ei bfr
.ends
.model las D(IS=1e-18 N=2 RS=4 CJO=2p)
V5 v5 0 5
V33 v33 0 3.3
* BOSA: laser anode on +5V_LD through the lead, cathode lead to the driver
Lla v5 la 2n
Dl la lk las
Llk lk ldk 2n
Rsn ldk sn 22
Csn sn v5 22p
* modulation pair, data AC-coupled from the GTS lane (+-200 mV per side), bases biased at 2.3 V through the 50 ohm terminations
Vd dp0 0 PWL(
+ 0.000000e+00 -1 4.822531e-09 -1 4.847531e-09 1 5.626286e-09 1 5.651286e-09 -1 9.645062e-09 -1
+ 9.670062e-09 1 1.125257e-08 1 1.127757e-08 -1 1.446759e-08 -1 1.449259e-08 1 1.527135e-08 1
+ 1.529635e-08 -1 1.607510e-08 -1 1.610010e-08 1 1.687886e-08 1 1.690386e-08 -1 1.929012e-08 -1
+ 1.931512e-08 1 2.250514e-08 1 2.253014e-08 -1 2.411265e-08 -1 2.413765e-08 1 2.491641e-08 1
+ 2.494141e-08 -1 2.732767e-08 -1 2.735267e-08 1 2.813143e-08 1 2.815643e-08 -1 2.893519e-08 -1
+ 2.896019e-08 1 3.054270e-08 1 3.056770e-08 -1 3.215021e-08 -1 3.217521e-08 1 3.456147e-08 1
+ 3.458647e-08 -1 3.536523e-08 -1 3.539023e-08 1 3.616898e-08 1 3.619398e-08 -1 3.697274e-08 -1
+ 3.699774e-08 1 3.777649e-08 1 3.780149e-08 -1 3.938400e-08 -1 3.940900e-08 1 4.340278e-08 1
+ 4.342778e-08 -1 4.420653e-08 -1 4.423153e-08 1 4.501029e-08 1 4.503529e-08 -1 4.822531e-08 -1
+ 4.825031e-08 1 5.063657e-08 1 5.066157e-08 -1 5.304784e-08 -1 5.307284e-08 1 5.385159e-08 1
+ 5.387659e-08 -1 5.545910e-08 -1 5.548410e-08 1 5.626286e-08 1 5.628786e-08 -1 5.787037e-08 -1
+ 5.789537e-08 1 5.947788e-08 1 5.950288e-08 -1 6.028164e-08 -1 6.030664e-08 1 6.188915e-08 1
+ 6.191415e-08 -1 6.269290e-08 -1 6.271790e-08 1 6.349666e-08 1 6.352166e-08 -1 6.430041e-08 -1
+ 6.432541e-08 1 6.590792e-08 1 6.593292e-08 -1 6.671168e-08 -1 6.673668e-08 1 6.992670e-08 1
+ 6.995170e-08 -1 7.073045e-08 -1 7.075545e-08 1 7.233796e-08 1 7.236296e-08 -1 7.474923e-08 -1
+ 7.477423e-08 1 7.635674e-08 1 7.638174e-08 -1 7.716049e-08 -1 7.718549e-08 1 7.796425e-08 1
+ 7.798925e-08 -1 7.957176e-08 -1 7.959676e-08 1 8.037551e-08 1 8.040051e-08 -1 8.117927e-08 -1
+ 8.120427e-08 1 8.359053e-08 1 8.361553e-08 -1 8.439429e-08 -1 8.441929e-08 1 8.680556e-08 1
+ 8.683056e-08 -1 8.841307e-08 -1 8.843807e-08 1 9.002058e-08 1 9.004558e-08 -1 9.162809e-08 -1
+ 9.165309e-08 1 9.243184e-08 1 9.245684e-08 -1 9.323560e-08 -1 9.326060e-08 1 9.403935e-08 1
+ 9.406435e-08 -1 9.484311e-08 -1 9.486811e-08 1 9.564686e-08 1 9.567186e-08 -1 9.645062e-08 -1
+ 9.647562e-08 1 1.020769e-07 1 1.021019e-07 -1 1.068994e-07 -1 1.069244e-07 1 1.077032e-07 1
+ 1.077282e-07 -1 1.117220e-07 -1 1.117470e-07 1 1.133295e-07 1 1.133545e-07 -1 1.165445e-07 -1
+ 1.165695e-07 1 1.173483e-07 1 1.173733e-07 -1 1.181520e-07 -1 1.181770e-07 1 1.189558e-07 1
+ 1.189808e-07 -1 1.213670e-07 -1 1.213920e-07 1 1.245820e-07 1 1.246070e-07 -1 1.261896e-07 -1
+ 1.262146e-07 1 1.269933e-07 1 1.270183e-07 -1 1.294046e-07 -1 1.294296e-07 1 1.302083e-07 1
+ 1.302333e-07 -1 1.310121e-07 -1 1.310371e-07 1 1.326196e-07 1 1.326446e-07 -1 1.342271e-07 -1
+ 1.342521e-07 1 1.366384e-07 1 1.366634e-07 -1 1.374421e-07 -1 1.374671e-07 1 1.382459e-07 1
+ 1.382709e-07 -1 1.390496e-07 -1 1.390746e-07 1 1.398534e-07 1 1.398784e-07 -1 1.414609e-07 -1
+ 1.414859e-07 1 1.454797e-07 1 1.455047e-07 -1 1.462834e-07 -1 1.463084e-07 1 1.470872e-07 1
+ 1.471122e-07 -1 1.503022e-07 -1 1.503272e-07 1 1.527135e-07 1 1.527385e-07 -1 1.551247e-07 -1
+ 1.551497e-07 1 1.559285e-07 1 1.559535e-07 -1 1.575360e-07 -1 1.575610e-07 1 1.583398e-07 1
+ 1.583648e-07 -1 1.599473e-07 -1 1.599723e-07 1 1.615548e-07 1 1.615798e-07 -1 1.623585e-07 -1
+ 1.623835e-07 1 1.639660e-07 1 1.639910e-07 -1 1.647698e-07 -1 1.647948e-07 1 1.655736e-07 1
+ 1.655986e-07 -1 1.663773e-07 -1 1.664023e-07 1 1.679848e-07 1 1.680098e-07 -1 1.687886e-07 -1
+ 1.688136e-07 1 1.720036e-07 1 1.720286e-07 -1 1.728074e-07 -1 1.728324e-07 1 1.744149e-07 1
+ 1.744399e-07 -1 1.768261e-07 -1 1.768511e-07 1 1.784336e-07 1 1.784586e-07 -1 1.792374e-07 -1
+ 1.792624e-07 1 1.800412e-07 1 1.800662e-07 -1 1.816487e-07 -1 1.816737e-07 1 1.824524e-07 1
+ 1.824774e-07 -1 1.832562e-07 -1 1.832812e-07 1 1.856674e-07 1 1.856924e-07 -1 1.864712e-07 -1
+ 1.864962e-07 1 1.888825e-07 1 1.889075e-07 -1 1.904900e-07 -1 1.905150e-07 1 1.920975e-07 1
+ 1.921225e-07 -1 1.937050e-07 -1 1.937300e-07 1 1.945087e-07 1 1.945337e-07 -1 1.953125e-07 -1
+ 1.953375e-07 1 1.961163e-07 1 1.961413e-07 -1 1.969200e-07 -1 1.969450e-07 1 1.977238e-07 1
+ 1.977488e-07 -1 1.985275e-07 -1 1.985525e-07 1 2.041538e-07 1 2.041788e-07 -1 2.089763e-07 -1
+ 2.090013e-07 1 2.097801e-07 1 2.098051e-07 -1 2.137989e-07 -1 2.138239e-07 1 2.154064e-07 1
+ 2.154314e-07 -1 2.186214e-07 -1 2.186464e-07 1 2.194252e-07 1 2.194502e-07 -1 2.202289e-07 -1
+ 2.202539e-07 1 2.210327e-07 1 2.210577e-07 -1 2.234439e-07 -1 2.234689e-07 1 2.266590e-07 1
+ 2.266840e-07 -1 2.282665e-07 -1 2.282915e-07 1 2.290702e-07 1 2.290952e-07 -1 2.314815e-07 -1
+ 2.315065e-07 1 2.322852e-07 1 2.323102e-07 -1 2.330890e-07 -1 2.331140e-07 1 2.346965e-07 1
+ 2.347215e-07 -1 2.363040e-07 -1 2.363290e-07 1 2.387153e-07 1 2.387403e-07 -1 2.395190e-07 -1
+ 2.395440e-07 1 2.403228e-07 1 2.403478e-07 -1 2.411265e-07 -1 2.411515e-07 1 2.419303e-07 1
+ 2.419553e-07 -1 2.435378e-07 -1 2.435628e-07 1 2.475566e-07 1 2.475816e-07 -1 2.483603e-07 -1
+ 2.483853e-07 1 2.491641e-07 1 2.491891e-07 -1 2.523791e-07 -1 2.524041e-07 1 2.547904e-07 1
+ 2.548154e-07 -1 2.572016e-07 -1 2.572266e-07 1 2.580054e-07 1 2.580304e-07 -1 2.596129e-07 -1
+ 2.596379e-07 1 2.604167e-07 1 2.604417e-07 -1 2.620242e-07 -1 2.620492e-07 1 2.636317e-07 1
+ 2.636567e-07 -1 2.644354e-07 -1 2.644604e-07 1 2.660430e-07 1 2.660680e-07 -1 2.668467e-07 -1
+ 2.668717e-07 1 2.676505e-07 1 2.676755e-07 -1 2.684542e-07 -1 2.684792e-07 1 2.700617e-07 1
+ 2.700867e-07 -1 2.708655e-07 -1 2.708905e-07 1 2.740805e-07 1 2.741055e-07 -1 2.748843e-07 -1
+ 2.749093e-07 1 2.764918e-07 1 2.765168e-07 -1 2.789030e-07 -1 2.789280e-07 1 2.805105e-07 1
+ 2.805355e-07 -1 2.813143e-07 -1 2.813393e-07 1 2.821181e-07 1 2.821431e-07 -1 2.837256e-07 -1
+ 2.837506e-07 1 2.845293e-07 1 2.845543e-07 -1 2.853331e-07 -1 2.853581e-07 1 2.877443e-07 1
+ 2.877693e-07 -1 2.885481e-07 -1 2.885731e-07 1 2.909594e-07 1 2.909844e-07 -1 2.925669e-07 -1
+ 2.925919e-07 1 2.941744e-07 1 2.941994e-07 -1 2.957819e-07 -1 2.958069e-07 1 2.965856e-07 1
+ 2.966106e-07 -1 2.973894e-07 -1 2.974144e-07 1 2.981932e-07 1 2.982182e-07 -1 2.989969e-07 -1
+ 2.990219e-07 1 2.998007e-07 1 2.998257e-07 -1 3.006044e-07 -1 3.006294e-07 1 3.062307e-07 1
+ 3.062557e-07 -1 3.110532e-07 -1 3.110782e-07 1 3.118570e-07 1 3.118820e-07 -1 3.158758e-07 -1
+ 3.159008e-07 1 3.174833e-07 1 3.175083e-07 -1 3.206983e-07 -1 3.207233e-07 1 3.215021e-07 1
+ 3.215271e-07 -1 3.223058e-07 -1 3.223308e-07 1 3.231096e-07 1 3.231346e-07 -1 3.255208e-07 -1
+ 3.255458e-07 1 3.287359e-07 1 3.287609e-07 -1 3.303434e-07 -1 3.303684e-07 1 3.311471e-07 1
+ 3.311721e-07 -1 3.335584e-07 -1 3.335834e-07 1 3.343621e-07 1 3.343871e-07 -1 3.351659e-07 -1
+ 3.351909e-07 1 3.367734e-07 1 3.367984e-07 -1 3.383809e-07 -1 3.384059e-07 1 3.407922e-07 1
+ 3.408172e-07 -1 3.415959e-07 -1 3.416209e-07 1 3.423997e-07 1 3.424247e-07 -1 3.432034e-07 -1
+ 3.432284e-07 1 3.440072e-07 1 3.440322e-07 -1 3.456147e-07 -1 3.456397e-07 1 3.496335e-07 1
+ 3.496585e-07 -1 3.504372e-07 -1 3.504622e-07 1 3.512410e-07 1 3.512660e-07 -1 3.544560e-07 -1
+ 3.544810e-07 1 3.568673e-07 1 3.568923e-07 -1 3.592785e-07 -1 3.593035e-07 1 3.600823e-07 1
+ 3.601073e-07 -1 3.616898e-07 -1 3.617148e-07 1 3.624936e-07 1 3.625186e-07 -1 3.641011e-07 -1
+ 3.641261e-07 1 3.657086e-07 1 3.657336e-07 -1 3.665123e-07 -1 3.665373e-07 1 3.681199e-07 1
+ 3.681449e-07 -1 3.689236e-07 -1 3.689486e-07 1 3.697274e-07 1 3.697524e-07 -1 3.705311e-07 -1
+ 3.705561e-07 1 3.721386e-07 1 3.721636e-07 -1 3.729424e-07 -1 3.729674e-07 1 3.761574e-07 1
+ 3.761824e-07 -1 3.769612e-07 -1 3.769862e-07 1 3.785687e-07 1 3.785937e-07 -1 3.809799e-07 -1
+ 3.810049e-07 1 3.825874e-07 1 3.826124e-07 -1 3.833912e-07 -1 3.834162e-07 1 3.841950e-07 1
+ 3.842200e-07 -1 3.858025e-07 -1 3.858275e-07 1 3.866062e-07 1 3.866312e-07 -1 3.874100e-07 -1
+ 3.874350e-07 1 3.898212e-07 1 3.898462e-07 -1 3.906250e-07 -1 3.906500e-07 1 3.930363e-07 1
+ 3.930613e-07 -1 3.946438e-07 -1 3.946688e-07 1 3.962513e-07 1 3.962763e-07 -1 3.978588e-07 -1
+ 3.978838e-07 1 3.986626e-07 1 3.986876e-07 -1 3.994663e-07 -1 3.994913e-07 1 4.002701e-07 1
+ 4.002951e-07 -1 4.010738e-07 -1 4.010988e-07 1 4.018776e-07 1 4.019026e-07 -1 4.026813e-07 -1
+ 4.027063e-07 1 4.083076e-07 1 4.083326e-07 -1 4.131301e-07 -1 4.131551e-07 1 4.139339e-07 1
+ 4.139589e-07 -1 4.179527e-07 -1 4.179777e-07 1 4.195602e-07 1 4.195852e-07 -1 4.227752e-07 -1
+ 4.228002e-07 1 4.235790e-07 1 4.236040e-07 -1 4.243827e-07 -1 4.244077e-07 1 4.251865e-07 1
+ 4.252115e-07 -1 4.275977e-07 -1 4.276227e-07 1 4.308128e-07 1 4.308378e-07 -1 4.324203e-07 -1
+ 4.324453e-07 1 4.332240e-07 1 4.332490e-07 -1 4.356353e-07 -1 4.356603e-07 1 4.364390e-07 1
+ 4.364640e-07 -1 4.372428e-07 -1 4.372678e-07 1 4.388503e-07 1 4.388753e-07 -1 4.404578e-07 -1
+ 4.404828e-07 1 4.428691e-07 1 4.428941e-07 -1 4.436728e-07 -1 4.436978e-07 1 4.444766e-07 1
+ 4.445016e-07 -1 4.452803e-07 -1 4.453053e-07 1 4.460841e-07 1 4.461091e-07 -1 4.476916e-07 -1
+ 4.477166e-07 1 4.517104e-07 1 4.517354e-07 -1 4.525141e-07 -1 4.525391e-07 1 4.533179e-07 1
+ 4.533429e-07 -1 4.565329e-07 -1 4.565579e-07 1 4.589442e-07 1 4.589692e-07 -1 4.613555e-07 -1
+ 4.613805e-07 1 4.621592e-07 1 4.621842e-07 -1 4.637667e-07 -1 4.637917e-07 1 4.645705e-07 1
+ 4.645955e-07 -1 4.661780e-07 -1 4.662030e-07 1 4.677855e-07 1 4.678105e-07 -1 4.685892e-07 -1
+ 4.686142e-07 1 4.701968e-07 1 4.702218e-07 -1 4.710005e-07 -1 4.710255e-07 1 4.718043e-07 1
+ 4.718293e-07 -1 4.726080e-07 -1 4.726330e-07 1 4.742155e-07 1 4.742405e-07 -1 4.750193e-07 -1
+ 4.750443e-07 1 4.782343e-07 1 4.782593e-07 -1 4.790381e-07 -1 4.790631e-07 1 4.806456e-07 1
+ 4.806706e-07 -1 4.830568e-07 -1 4.830818e-07 1 4.846644e-07 1 4.846894e-07 -1 4.854681e-07 -1
+ 4.854931e-07 1 4.862719e-07 1 4.862969e-07 -1 4.878794e-07 -1 4.879044e-07 1 4.886831e-07 1
+ 4.887081e-07 -1 4.894869e-07 -1 4.895119e-07 1 4.918981e-07 1 4.919231e-07 -1 4.927019e-07 -1
+ 4.927269e-07 1 4.951132e-07 1 4.951382e-07 -1 4.967207e-07 -1 4.967457e-07 1 4.983282e-07 1
+ 4.983532e-07 -1 4.999357e-07 -1 4.999607e-07 1 5.007395e-07 1 5.007645e-07 -1 5.015432e-07 -1
+ 5.015682e-07 1 5.023470e-07 1 5.023720e-07 -1 5.031507e-07 -1 5.031757e-07 1 5.039545e-07 1
+ 5.039795e-07 -1 5.047582e-07 -1 5.047832e-07 1 5.103845e-07 1 5.104095e-07 -1 5.152070e-07 -1
+ 5.152320e-07 1 5.160108e-07 1 5.160358e-07 -1 5.200296e-07 -1 5.200546e-07 1 5.216371e-07 1
+ 5.216621e-07 -1 5.248521e-07 -1 5.248771e-07 1 5.256559e-07 1 5.256809e-07 -1 5.264596e-07 -1
+ 5.264846e-07 1 5.272634e-07 1 5.272884e-07 -1 5.296746e-07 -1 5.296996e-07 1 5.328897e-07 1
+ 5.329147e-07 -1 5.344972e-07 -1 5.345222e-07 1 5.353009e-07 1 5.353259e-07 -1 5.377122e-07 -1
+ 5.377372e-07 1 5.385159e-07 1 5.385409e-07 -1 5.393197e-07 -1 5.393447e-07 1 5.409272e-07 1
+ 5.409522e-07 -1 5.425347e-07 -1 5.425597e-07 1 5.449460e-07 1 5.449710e-07 -1 5.457497e-07 -1
+ 5.457747e-07 1 5.465535e-07 1 5.465785e-07 -1 5.473573e-07 -1 5.473823e-07 1 5.481610e-07 1
+ 5.481860e-07 -1 5.497685e-07 -1 5.497935e-07 1 5.537873e-07 1 5.538123e-07 -1 5.545910e-07 -1
+ 5.546160e-07 1 5.553948e-07 1 5.554198e-07 -1 5.586098e-07 -1 5.586348e-07 1 5.610211e-07 1
+ 5.610461e-07 -1 5.634324e-07 -1 5.634574e-07 1 5.642361e-07 1 5.642611e-07 -1 5.658436e-07 -1
+ 5.658686e-07 1 5.666474e-07 1 5.666724e-07 -1 5.682549e-07 -1 5.682799e-07 1 5.698624e-07 1
+ 5.698874e-07 -1 5.706662e-07 -1 5.706912e-07 1 5.722737e-07 1 5.722987e-07 -1 5.730774e-07 -1
+ 5.731024e-07 1 5.738812e-07 1 5.739062e-07 -1 5.746849e-07 -1 5.747099e-07 1 5.762924e-07 1
+ 5.763174e-07 -1 5.770962e-07 -1 5.771212e-07 1 5.803112e-07 1 5.803362e-07 -1 5.811150e-07 -1
+ 5.811400e-07 1 5.827225e-07 1 5.827475e-07 -1 5.851337e-07 -1 5.851587e-07 1 5.867413e-07 1
+ 5.867663e-07 -1 5.875450e-07 -1 5.875700e-07 1 5.883488e-07 1 5.883738e-07 -1 5.899563e-07 -1
+ 5.899813e-07 1 5.907600e-07 1 5.907850e-07 -1 5.915638e-07 -1 5.915888e-07 1 5.939751e-07 1
+ 5.940001e-07 -1 5.947788e-07 -1 5.948038e-07 1 5.971901e-07 1 5.972151e-07 -1 5.987976e-07 -1
+ 5.988226e-07 1 6.004051e-07 1 6.004301e-07 -1 6.020126e-07 -1 6.020376e-07 1 6.028164e-07 1
+ 6.028414e-07 -1 6.036201e-07 -1 6.036451e-07 1 6.044239e-07 1 6.044489e-07 -1 6.052276e-07 -1
+ 6.052526e-07 1 6.060314e-07 1 6.060564e-07 -1 6.068351e-07 -1 6.068601e-07 1 6.124614e-07 1
+ 6.124864e-07 -1 6.172840e-07 -1 6.173090e-07 1 6.180877e-07 1 6.181127e-07 -1 6.221065e-07 -1
+ 6.221315e-07 1 6.237140e-07 1 6.237390e-07 -1 6.269290e-07 -1 6.269540e-07 1 6.277328e-07 1
+ 6.277578e-07 -1 6.285365e-07 -1 6.285615e-07 1 6.293403e-07 1 6.293653e-07 -1 6.317515e-07 -1
+ 6.317765e-07 1 6.349666e-07 1 6.349916e-07 -1 6.365741e-07 -1 6.365991e-07 1 6.373778e-07 1
+ 6.374028e-07 -1 6.397891e-07 -1 6.398141e-07 1 6.405928e-07 1 6.406178e-07 -1 6.413966e-07 -1
+ 6.414216e-07 1 6.430041e-07 1 6.430291e-07 -1 6.446116e-07 -1 6.446366e-07 1 6.470229e-07 1
+ 6.470479e-07 -1 6.478266e-07 -1 6.478516e-07 1 6.486304e-07 1 6.486554e-07 -1 6.494342e-07 -1
+ 6.494592e-07 1 6.502379e-07 1 6.502629e-07 -1 6.518454e-07 -1 6.518704e-07 1 6.558642e-07 1
+ 6.558892e-07 -1 6.566680e-07 -1 6.566930e-07 1 6.574717e-07 1 6.574967e-07 -1 6.606867e-07 -1
+ 6.607117e-07 1 6.630980e-07 1 6.631230e-07 -1 6.655093e-07 -1 6.655343e-07 1 6.663130e-07 1
+ 6.663380e-07 -1 6.679205e-07 -1 6.679455e-07 1 6.687243e-07 1 6.687493e-07 -1 6.703318e-07 -1
+ 6.703568e-07 1 6.719393e-07 1 6.719643e-07 -1 6.727431e-07 -1 6.727681e-07 1 6.743506e-07 1
+ 6.743756e-07 -1 6.751543e-07 -1 6.751793e-07 1 6.759581e-07 1 6.759831e-07 -1 6.767618e-07 -1
+ 6.767868e-07 1 6.783693e-07 1 6.783943e-07 -1 6.791731e-07 -1 6.791981e-07 1 6.823881e-07 1
+ 6.824131e-07 -1 6.831919e-07 -1 6.832169e-07 1 6.847994e-07 1 6.848244e-07 -1 6.872106e-07 -1
+ 6.872356e-07 1 6.888182e-07 1 6.888432e-07 -1 6.896219e-07 -1 6.896469e-07 1 6.904257e-07 1
+ 6.904507e-07 -1 6.920332e-07 -1 6.920582e-07 1 6.928369e-07 1 6.928619e-07 -1 6.936407e-07 -1
+ 6.936657e-07 1 6.960520e-07 1 6.960770e-07 -1 6.968557e-07 -1 6.968807e-07 1 6.992670e-07 1
+ 6.992920e-07 -1 7.008745e-07 -1 7.008995e-07 1 7.024820e-07 1 7.025070e-07 -1 7.040895e-07 -1
+ 7.041145e-07 1 7.048933e-07 1 7.049183e-07 -1 7.056970e-07 -1 7.057220e-07 1 7.065008e-07 1
+ 7.065258e-07 -1 7.073045e-07 -1 7.073295e-07 1 7.081083e-07 1 7.081333e-07 -1 7.089120e-07 -1
+ 7.089370e-07 1 7.145383e-07 1 7.145633e-07 -1 7.193609e-07 -1 7.193859e-07 1 7.201646e-07 1
+ 7.201896e-07 -1 7.241834e-07 -1 7.242084e-07 1 7.257909e-07 1 7.258159e-07 -1 7.290059e-07 -1
+ 7.290309e-07 1 7.298097e-07 1 7.298347e-07 -1 7.306134e-07 -1 7.306384e-07 1 7.314172e-07 1
+ 7.314422e-07 -1 7.338284e-07 -1 7.338534e-07 1 7.370435e-07 1 7.370685e-07 -1 7.386510e-07 -1
+ 7.386760e-07 1 7.394547e-07 1 7.394797e-07 -1 7.418660e-07 -1 7.418910e-07 1 7.426698e-07 1
+ 7.426948e-07 -1 7.434735e-07 -1 7.434985e-07 1 7.450810e-07 1 7.451060e-07 -1 7.466885e-07 -1
+ 7.467135e-07 1 7.490998e-07 1 7.491248e-07 -1 7.499035e-07 -1 7.499285e-07 1 7.507073e-07 1
+ 7.507323e-07 -1 7.515111e-07 -1 7.515361e-07 1 7.523148e-07 1 7.523398e-07 -1 7.539223e-07 -1
+ 7.539473e-07 1 7.579411e-07 1 7.579661e-07 -1 7.587449e-07 -1 7.587699e-07 1 7.595486e-07 1
+ 7.595736e-07 -1 7.627636e-07 -1 7.627886e-07 1 7.651749e-07 1 7.651999e-07 -1 7.675862e-07 -1
+ 7.676112e-07 1 7.683899e-07 1 7.684149e-07 -1 7.699974e-07 -1 7.700224e-07 1 7.708012e-07 1
+ 7.708262e-07 -1 7.724087e-07 -1 7.724337e-07 1 7.740162e-07 1 7.740412e-07 -1 7.748200e-07 -1
+ 7.748450e-07 1 7.764275e-07 1 7.764525e-07 -1 7.772312e-07 -1 7.772562e-07 1 7.780350e-07 1
+ 7.780600e-07 -1 7.788387e-07 -1 7.788637e-07 1 7.804462e-07 1 7.804712e-07 -1 7.812500e-07 -1
+ 7.812750e-07 1 7.844650e-07 1 7.844900e-07 -1 7.852688e-07 -1 7.852938e-07 1 7.868763e-07 1
+ 7.869013e-07 -1 7.892876e-07 -1 7.893126e-07 1 7.908951e-07 1 7.909201e-07 -1 7.916988e-07 -1
+ 7.917238e-07 1 7.925026e-07 1 7.925276e-07 -1 7.941101e-07 -1 7.941351e-07 1 7.949138e-07 1
+ 7.949388e-07 -1 7.957176e-07 -1 7.957426e-07 1 7.981289e-07 1 7.981539e-07 -1 7.989326e-07 -1
+ 7.989576e-07 1 8.013439e-07 1 8.013689e-07 -1 8.029514e-07 -1 8.029764e-07 1 8.045589e-07 1
+ 8.045839e-07 -1 8.061664e-07 -1 8.061914e-07 1 8.069702e-07 1 8.069952e-07 -1 8.077739e-07 -1
+ 8.077989e-07 1 8.085777e-07 1 8.086027e-07 -1 8.093814e-07 -1 8.094064e-07 1 8.101852e-07 1
+ 8.102102e-07 -1 8.109889e-07 -1 8.110139e-07 1 8.166152e-07 1 8.166402e-07 -1 8.214378e-07 -1
+ 8.214628e-07 1 8.222415e-07 1 8.222665e-07 -1 8.262603e-07 -1 8.262853e-07 1 8.278678e-07 1
+ 8.278928e-07 -1 8.310828e-07 -1 8.311078e-07 1 8.318866e-07 1 8.319116e-07 -1 8.326903e-07 -1
+ 8.327153e-07 1 8.334941e-07 1 8.335191e-07 -1 8.359053e-07 -1 8.359303e-07 1 8.391204e-07 1
+ 8.391454e-07 -1 8.407279e-07 -1 8.407529e-07 1 8.415316e-07 1 8.415566e-07 -1 8.439429e-07 -1
+ 8.439679e-07 1 8.447467e-07 1 8.447717e-07 -1 8.455504e-07 -1 8.455754e-07 1 8.471579e-07 1
+ 8.471829e-07 -1 8.487654e-07 -1 8.487904e-07 1 8.511767e-07 1 8.512017e-07 -1 8.519805e-07 -1
+ 8.520055e-07 1 8.527842e-07 1 8.528092e-07 -1 8.535880e-07 -1 8.536130e-07 1 8.543917e-07 1
+ 8.544167e-07 -1 8.559992e-07 -1 8.560242e-07 1 8.600180e-07 1 8.600430e-07 -1 8.608218e-07 -1
+ 8.608468e-07 1 8.616255e-07 1 8.616505e-07 -1 8.648405e-07 -1 8.648655e-07 1 8.672518e-07 1
+ 8.672768e-07 -1 8.696631e-07 -1 8.696881e-07 1 8.704668e-07 1 8.704918e-07 -1 8.720743e-07 -1
+ 8.720993e-07 1 8.728781e-07 1 8.729031e-07 -1 8.744856e-07 -1 8.745106e-07 1 8.760931e-07 1
+ 8.761181e-07 -1 8.768969e-07 -1 8.769219e-07 1 8.785044e-07 1 8.785294e-07 -1 8.793081e-07 -1
+ 8.793331e-07 1 8.801119e-07 1 8.801369e-07 -1 8.809156e-07 -1 8.809406e-07 1 8.825231e-07 1
+ 8.825481e-07 -1 8.833269e-07 -1 8.833519e-07 1 8.865419e-07 1 8.865669e-07 -1 8.873457e-07 -1
+ 8.873707e-07 1 8.889532e-07 1 8.889782e-07 -1 8.913645e-07 -1 8.913895e-07 1 8.929720e-07 1
+ 8.929970e-07 -1 8.937757e-07 -1 8.938007e-07 1 8.945795e-07 1 8.946045e-07 -1 8.961870e-07 -1
+ 8.962120e-07 1 8.969907e-07 1 8.970157e-07 -1 8.977945e-07 -1 8.978195e-07 1 9.002058e-07 1
+ 9.002308e-07 -1 9.010095e-07 -1 9.010345e-07 1 9.034208e-07 1 9.034458e-07 -1 9.050283e-07 -1
+ 9.050533e-07 1 9.066358e-07 1 9.066608e-07 -1 9.082433e-07 -1 9.082683e-07 1 9.090471e-07 1
+ 9.090721e-07 -1 9.098508e-07 -1 9.098758e-07 1 9.106546e-07 1 9.106796e-07 -1 9.114583e-07 -1
+ 9.114833e-07 1 9.122621e-07 1 9.122871e-07 -1 9.130658e-07 -1 9.130908e-07 1 9.186921e-07 1
+ 9.187171e-07 -1 9.235147e-07 -1 9.235397e-07 1 9.243184e-07 1 9.243434e-07 -1 9.283372e-07 -1
+ 9.283622e-07 1 9.299447e-07 1 9.299697e-07 -1 9.331597e-07 -1 9.331847e-07 1 9.339635e-07 1
+ 9.339885e-07 -1 9.347672e-07 -1 9.347922e-07 1 9.355710e-07 1 9.355960e-07 -1 9.379823e-07 -1
+ 9.380073e-07 1 9.411973e-07 1 9.412223e-07 -1 9.428048e-07 -1 9.428298e-07 1 9.436085e-07 1
+ 9.436335e-07 -1 9.460198e-07 -1 9.460448e-07 1 9.468236e-07 1 9.468486e-07 -1 9.476273e-07 -1
+ 9.476523e-07 1 9.492348e-07 1 9.492598e-07 -1 9.508423e-07 -1 9.508673e-07 1 9.532536e-07 1
+ 9.532786e-07 -1 9.540574e-07 -1 9.540824e-07 1 9.548611e-07 1 9.548861e-07 -1 9.556649e-07 -1
+ 9.556899e-07 1 9.564686e-07 1 9.564936e-07 -1 9.580761e-07 -1 9.581011e-07 1 9.620949e-07 1
+ 9.621199e-07 -1 9.628987e-07 -1 9.629237e-07 1 9.637024e-07 1 9.637274e-07 -1 9.669174e-07 -1
+ 9.669424e-07 1 9.693287e-07 1 9.693537e-07 -1 9.717400e-07 -1 9.717650e-07 1 9.725437e-07 1
+ 9.725687e-07 -1 9.741512e-07 -1 9.741762e-07 1 9.749550e-07 1 9.749800e-07 -1 9.765625e-07 -1
+ 9.765875e-07 1 9.781700e-07 1 9.781950e-07 -1 9.789738e-07 -1 9.789988e-07 1 9.805813e-07 1
+ 9.806063e-07 -1 9.813850e-07 -1 9.814100e-07 1 9.821888e-07 1 9.822138e-07 -1 9.829925e-07 -1
+ 9.830175e-07 1 9.846001e-07 1 9.846251e-07 -1 9.854038e-07 -1 9.854288e-07 1 9.886188e-07 1
+ 9.886438e-07 -1 9.894226e-07 -1 9.894476e-07 1 9.910301e-07 1 9.910551e-07 -1 9.934414e-07 -1
+ 9.934664e-07 1 9.950489e-07 1 9.950739e-07 -1 9.958526e-07 -1 9.958776e-07 1 9.966564e-07 1
+ 9.966814e-07 -1 9.982639e-07 -1 9.982889e-07 1 9.990676e-07 1 9.990926e-07 -1 9.998714e-07 -1
+ 9.998964e-07 1 1.002283e-06 1 1.002308e-06 -1 1.003086e-06 -1 1.003111e-06 1 1.005498e-06 1
+ 1.005523e-06 -1 1.007105e-06 -1 1.007130e-06 1 1.008713e-06 1 1.008738e-06 -1 1.010320e-06 -1
+ 1.010345e-06 1 1.011124e-06 1 1.011149e-06 -1 1.011928e-06 -1 1.011953e-06 1 1.012731e-06 1
+ 1.012756e-06 -1 1.013535e-06 -1 1.013560e-06 1 1.014339e-06 1 1.014364e-06 -1 1.015143e-06 -1
+ 1.015168e-06 1 1.020769e-06 1 1.020794e-06 -1 1.025592e-06 -1 1.025617e-06 1 1.026395e-06 1
+ 1.026420e-06 -1 1.030414e-06 -1 1.030439e-06 1 1.032022e-06 1 1.032047e-06 -1 1.035237e-06 -1
+ 1.035262e-06 1 1.036040e-06 1 1.036065e-06 -1 1.036844e-06 -1 1.036869e-06 1 1.037648e-06 1
+ 1.037673e-06 -1 1.040059e-06 -1 1.040084e-06 1 1.043274e-06 1 1.043299e-06 -1 1.044882e-06 -1
+ 1.044907e-06 1 1.045685e-06 1 1.045710e-06 -1 1.048097e-06 -1 1.048122e-06 1 1.048900e-06 1
+ 1.048925e-06 -1 1.049704e-06 -1 1.049729e-06 1 1.051312e-06 1 1.051337e-06 -1 1.052919e-06 -1
+ 1.052944e-06 1 1.055331e-06 1 1.055356e-06 -1 1.056134e-06 -1 1.056159e-06 1 1.056938e-06 1
+ 1.056963e-06 -1 1.057742e-06 -1 1.057767e-06 1 1.058546e-06 1 1.058571e-06 -1 1.060153e-06 -1
+ 1.060178e-06 1 1.064172e-06 1 1.064197e-06 -1 1.064976e-06 -1 1.065001e-06 1 1.065779e-06 1
+ 1.065804e-06 -1 1.068994e-06 -1 1.069019e-06 1 1.071406e-06 1 1.071431e-06 -1 1.073817e-06 -1
+ 1.073842e-06 1 1.074621e-06 1 1.074646e-06 -1 1.076228e-06 -1 1.076253e-06 1 1.077032e-06 1
+ 1.077057e-06 -1 1.078639e-06 -1 1.078664e-06 1 1.080247e-06 1 1.080272e-06 -1 1.081051e-06 -1
+ 1.081076e-06 1 1.082658e-06 1 1.082683e-06 -1 1.083462e-06 -1 1.083487e-06 1 1.084266e-06 1
+ 1.084291e-06 -1 1.085069e-06 -1 1.085094e-06 1 1.086677e-06 1 1.086702e-06 -1 1.087481e-06 -1
+ 1.087506e-06 1 1.090696e-06 1 1.090721e-06 -1 1.091499e-06 -1 1.091524e-06 1 1.093107e-06 1
+ 1.093132e-06 -1 1.095518e-06 -1 1.095543e-06 1 1.097126e-06 1 1.097151e-06 -1 1.097930e-06 -1
+ 1.097955e-06 1 1.098733e-06 1 1.098758e-06 -1 1.100341e-06 -1 1.100366e-06 1 1.101145e-06 1
+ 1.101170e-06 -1 1.101948e-06 -1 1.101973e-06 1 1.104360e-06 1 1.104385e-06 -1 1.105163e-06 -1
+ 1.105188e-06 1 1.107575e-06 1 1.107600e-06 -1 1.109182e-06 -1 1.109207e-06 1 1.110790e-06 1
+ 1.110815e-06 -1 1.112397e-06 -1 1.112422e-06 1 1.113201e-06 1 1.113226e-06 -1 1.114005e-06 -1
+ 1.114030e-06 1 1.114808e-06 1 1.114833e-06 -1 1.115612e-06 -1 1.115637e-06 1 1.116416e-06 1
+ 1.116441e-06 -1 1.117220e-06 -1 1.117245e-06 1 1.122846e-06 1 1.122871e-06 -1 1.127668e-06 -1
+ 1.127693e-06 1 1.128472e-06 1 1.128497e-06 -1 1.132491e-06 -1 1.132516e-06 1 1.134099e-06 1
+ 1.134124e-06 -1 1.137314e-06 -1 1.137339e-06 1 1.138117e-06 1 1.138142e-06 -1 1.138921e-06 -1
+ 1.138946e-06 1 1.139725e-06 1 1.139750e-06 -1 1.142136e-06 -1 1.142161e-06 1 1.145351e-06 1
+ 1.145376e-06 -1 1.146959e-06 -1 1.146984e-06 1 1.147762e-06 1 1.147787e-06 -1 1.150174e-06 -1
+ 1.150199e-06 1 1.150977e-06 1 1.151002e-06 -1 1.151781e-06 -1 1.151806e-06 1 1.153389e-06 1
+ 1.153414e-06 -1 1.154996e-06 -1 1.155021e-06 1 1.157407e-06 1 1.157432e-06 -1 1.158211e-06 -1
+ 1.158236e-06 1 1.159015e-06 1 1.159040e-06 -1 1.159819e-06 -1 1.159844e-06 1 1.160622e-06 1
+ 1.160647e-06 -1 1.162230e-06 -1 1.162255e-06 1 1.166249e-06 1 1.166274e-06 -1 1.167052e-06 -1
+ 1.167077e-06 1 1.167856e-06 1 1.167881e-06 -1 1.171071e-06 -1 1.171096e-06 1 1.173483e-06 1
+ 1.173508e-06 -1 1.175894e-06 -1 1.175919e-06 1 1.176698e-06 1 1.176723e-06 -1 1.178305e-06 -1
+ 1.178330e-06 1 1.179109e-06 1 1.179134e-06 -1 1.180716e-06 -1 1.180741e-06 1 1.182324e-06 1
+ 1.182349e-06 -1 1.183128e-06 -1 1.183153e-06 1 1.184735e-06 1 1.184760e-06 -1 1.185539e-06 -1
+ 1.185564e-06 1 1.186343e-06 1 1.186368e-06 -1 1.187146e-06 -1 1.187171e-06 1 1.188754e-06 1
+ 1.188779e-06 -1 1.189558e-06 -1 1.189583e-06 1 1.192773e-06 1 1.192798e-06 -1 1.193576e-06 -1
+ 1.193601e-06 1 1.195184e-06 1 1.195209e-06 -1 1.197595e-06 -1 1.197620e-06 1 1.199203e-06 1
+ 1.199228e-06 -1 1.200006e-06 -1 1.200031e-06 1 1.200810e-06 1 1.200835e-06 -1 1.202418e-06 -1
+ 1.202443e-06 1 1.203221e-06 1 1.203246e-06 -1 1.204025e-06 -1 1.204050e-06 1 1.206436e-06 1
+ 1.206461e-06 -1 1.207240e-06 -1 1.207265e-06 1 1.209651e-06 1 1.209676e-06 -1 1.211259e-06 -1
+ 1.211284e-06 1 1.212867e-06 1 1.212892e-06 -1 1.214474e-06 -1 1.214499e-06 1 1.215278e-06 1
+ 1.215303e-06 -1 1.216082e-06 -1 1.216107e-06 1 1.216885e-06 1 1.216910e-06 -1 1.217689e-06 -1
+ 1.217714e-06 1 1.218493e-06 1 1.218518e-06 -1 1.219297e-06 -1 1.219322e-06 1 1.224923e-06 1
+ 1.224948e-06 -1 1.229745e-06 -1 1.229770e-06 1 1.230549e-06 1 1.230574e-06 -1 1.234568e-06 -1
+ 1.234593e-06 1 1.236175e-06 1 1.236200e-06 -1 1.239390e-06 -1 1.239415e-06 1 1.240194e-06 1
+ 1.240219e-06 -1 1.240998e-06 -1 1.241023e-06 1 1.241802e-06 1 1.241827e-06 -1 1.244213e-06 -1
+ 1.244238e-06 1 1.247428e-06 1 1.247453e-06 -1 1.249035e-06 -1 1.249060e-06 1 1.249839e-06 1
+ 1.249864e-06 -1 1.252251e-06 -1 1.252276e-06 1 1.253054e-06 1 1.253079e-06 -1 1.253858e-06 -1
+ 1.253883e-06 1 1.255466e-06 1 1.255491e-06 -1 1.257073e-06 -1 1.257098e-06 1 1.259484e-06 1
+ 1.259509e-06 -1 1.260288e-06 -1 1.260313e-06 1 1.261092e-06 1 1.261117e-06 -1 1.261896e-06 -1
+ 1.261921e-06 1 1.262699e-06 1 1.262724e-06 -1 1.264307e-06 -1 1.264332e-06 1 1.268326e-06 1
+ 1.268351e-06 -1 1.269129e-06 -1 1.269154e-06 1 1.269933e-06 1 1.269958e-06 -1 1.273148e-06 -1
+ 1.273173e-06 1 1.275559e-06 1 1.275584e-06 -1 1.277971e-06 -1 1.277996e-06 1 1.278774e-06 1
+ 1.278799e-06 -1 1.280382e-06 -1 1.280407e-06 1 1.281186e-06 1 1.281211e-06 -1 1.282793e-06 -1
+ 1.282818e-06 1 1.284401e-06 1 1.284426e-06 -1 1.285204e-06 -1 1.285229e-06 1 1.286812e-06 1
+ 1.286837e-06 -1 1.287616e-06 -1 1.287641e-06 1 1.288419e-06 1 1.288444e-06 -1 1.289223e-06 -1
+ 1.289248e-06 1 1.290831e-06 1 1.290856e-06 -1 1.291635e-06 -1 1.291660e-06 1 1.294850e-06 1
+ 1.294875e-06 -1 1.295653e-06 -1 1.295678e-06 1 1.297261e-06 1 1.297286e-06 -1 1.299672e-06 -1
+ 1.299697e-06 1 1.301280e-06 1 1.301305e-06 -1 1.302083e-06 -1 1.302108e-06 1 1.302887e-06 1
+ 1.302912e-06 -1 1.304495e-06 -1 1.304520e-06 1 1.305298e-06 1 1.305323e-06 -1 1.306102e-06 -1
+ 1.306127e-06 1 1.308513e-06 1 1.308538e-06 -1 1.309317e-06 -1 1.309342e-06 1 1.311728e-06 1
+ 1.311753e-06 -1 1.313336e-06 -1 1.313361e-06 1 1.314943e-06 1 1.314968e-06 -1 1.316551e-06 -1
+ 1.316576e-06 1 1.317355e-06 1 1.317380e-06 -1 1.318158e-06 -1 1.318183e-06 1 1.318962e-06 1
+ 1.318987e-06 -1 1.319766e-06 -1 1.319791e-06 1 1.320570e-06 1 1.320595e-06 -1 1.321373e-06 -1
+ 1.321398e-06 1 1.327000e-06 1 1.327025e-06 -1 1.331822e-06 -1 1.331847e-06 1 1.332626e-06 1
+ 1.332651e-06 -1 1.336645e-06 -1 1.336670e-06 1 1.338252e-06 1 1.338277e-06 -1 1.341467e-06 -1
+ 1.341492e-06 1 1.342271e-06 1 1.342296e-06 -1 1.343075e-06 -1 1.343100e-06 1 1.343879e-06 1
+ 1.343904e-06 -1 1.346290e-06 -1 1.346315e-06 1 1.349505e-06 1 1.349530e-06 -1 1.351112e-06 -1
+ 1.351137e-06 1 1.351916e-06 1 1.351941e-06 -1 1.354327e-06 -1 1.354352e-06 1 1.355131e-06 1
+ 1.355156e-06 -1 1.355935e-06 -1 1.355960e-06 1 1.357542e-06 1 1.357567e-06 -1 1.359150e-06 -1
+ 1.359175e-06 1 1.361561e-06 1 1.361586e-06 -1 1.362365e-06 -1 1.362390e-06 1 1.363169e-06 1
+ 1.363194e-06 -1 1.363972e-06 -1 1.363997e-06 1 1.364776e-06 1 1.364801e-06 -1 1.366384e-06 -1
+ 1.366409e-06 1 1.370403e-06 1 1.370428e-06 -1 1.371206e-06 -1 1.371231e-06 1 1.372010e-06 1
+ 1.372035e-06 -1 1.375225e-06 -1 1.375250e-06 1 1.377636e-06 1 1.377661e-06 -1 1.380048e-06 -1
+ 1.380073e-06 1 1.380851e-06 1 1.380876e-06 -1 1.382459e-06 -1 1.382484e-06 1 1.383263e-06 1
+ 1.383288e-06 -1 1.384870e-06 -1 1.384895e-06 1 1.386478e-06 1 1.386503e-06 -1 1.387281e-06 -1
+ 1.387306e-06 1 1.388889e-06 1 1.388914e-06 -1 1.389693e-06 -1 1.389718e-06 1 1.390496e-06 1
+ 1.390521e-06 -1 1.391300e-06 -1 1.391325e-06 1 1.392908e-06 1 1.392933e-06 -1 1.393711e-06 -1
+ 1.393736e-06 1 1.396926e-06 1 1.396951e-06 -1 1.397730e-06 -1 1.397755e-06 1 1.399338e-06 1
+ 1.399363e-06 -1 1.401749e-06 -1 1.401774e-06 1 1.403356e-06 1 1.403381e-06 -1 1.404160e-06 -1
+ 1.404185e-06 1 1.404964e-06 1 1.404989e-06 -1 1.406572e-06 -1 1.406597e-06 1 1.407375e-06 1
+ 1.407400e-06 -1 1.408179e-06 -1 1.408204e-06 1 1.410590e-06 1 1.410615e-06 -1 1.411394e-06 -1
+ 1.411419e-06 1 1.413805e-06 1 1.413830e-06 -1 1.415413e-06 -1 1.415438e-06 1 1.417020e-06 1
+ 1.417045e-06 -1 1.418628e-06 -1 1.418653e-06 1 1.419432e-06 1 1.419457e-06 -1 1.420235e-06 -1
+ 1.420260e-06 1 1.421039e-06 1 1.421064e-06 -1 1.421843e-06 -1 1.421868e-06 1 1.422647e-06 1
+ 1.422672e-06 -1 1.423450e-06 -1 1.423475e-06 1 1.429077e-06 1 1.429102e-06 -1 1.433899e-06 -1
+ 1.433924e-06 1 1.434703e-06 1 1.434728e-06 -1 1.438722e-06 -1 1.438747e-06 1 1.440329e-06 1
+ 1.440354e-06 -1 1.443544e-06 -1 1.443569e-06 1 1.444348e-06 1 1.444373e-06 -1 1.445152e-06 -1
+ 1.445177e-06 1 1.445956e-06 1 1.445981e-06 -1 1.448367e-06 -1 1.448392e-06 1 1.451582e-06 1
+ 1.451607e-06 -1 1.453189e-06 -1 1.453214e-06 1 1.453993e-06 1 1.454018e-06 -1 1.456404e-06 -1
+ 1.456429e-06 1 1.457208e-06 1 1.457233e-06 -1 1.458012e-06 -1 1.458037e-06 1 1.459619e-06 1
+ 1.459644e-06 -1 1.461227e-06 -1 1.461252e-06 1 1.463638e-06 1 1.463663e-06 -1 1.464442e-06 -1
+ 1.464467e-06 1 1.465246e-06 1 1.465271e-06 -1 1.466049e-06 -1 1.466074e-06 1 1.466853e-06 1
+ 1.466878e-06 -1 1.468461e-06 -1 1.468486e-06 1 1.472479e-06 1 1.472504e-06 -1 1.473283e-06 -1
+ 1.473308e-06 1 1.474087e-06 1 1.474112e-06 -1 1.477302e-06 -1 1.477327e-06 1 1.479713e-06 1
+ 1.479738e-06 -1 1.482124e-06 -1 1.482149e-06 1 1.482928e-06 1 1.482953e-06 -1 1.484536e-06 -1
+ 1.484561e-06 1 1.485340e-06 1 1.485365e-06 -1 1.486947e-06 -1 1.486972e-06 1 1.488555e-06 1
+ 1.488580e-06 -1 1.489358e-06 -1 1.489383e-06 1 1.490966e-06 1 1.490991e-06 -1 1.491770e-06 -1
+ 1.491795e-06 1 1.492573e-06 1 1.492598e-06 -1 1.493377e-06 -1 1.493402e-06 1 1.494985e-06 1
+ 1.495010e-06 -1 1.495788e-06 -1 1.495813e-06 1 1.499003e-06 1 1.499028e-06 -1 1.499807e-06 -1
+ 1.499832e-06 1 1.501415e-06 1 1.501440e-06 -1 1.503826e-06 -1 1.503851e-06 1 1.505433e-06 1
+ 1.505458e-06 -1 1.506237e-06 -1 1.506262e-06 1 1.507041e-06 1 1.507066e-06 -1 1.508648e-06 -1
+ 1.508673e-06 1 1.509452e-06 1 1.509477e-06 -1 1.510256e-06 -1 1.510281e-06 1 1.512667e-06 1
+ 1.512692e-06 -1 1.513471e-06 -1 1.513496e-06 1 1.515882e-06 1 1.515907e-06 -1 1.517490e-06 -1
+ 1.517515e-06 1 1.519097e-06 1 1.519122e-06 -1 1.520705e-06 -1 1.520730e-06 1 1.521508e-06 1
+ 1.521533e-06 -1 1.522312e-06 -1 1.522337e-06 1 1.523116e-06 1 1.523141e-06 -1 1.523920e-06 -1
+ 1.523945e-06 1 1.524724e-06 1 1.524749e-06 -1 1.525527e-06 -1 1.525552e-06 1 1.531154e-06 1
+ 1.531179e-06 -1 1.535976e-06 -1 1.536001e-06 1 1.536780e-06 1 1.536805e-06 -1 1.540799e-06 -1
+ 1.540824e-06 1 1.542406e-06 1 1.542431e-06 -1 1.545621e-06 -1 1.545646e-06 1 1.546425e-06 1
+ 1.546450e-06 -1 1.547229e-06 -1 1.547254e-06 1 1.548032e-06 1 1.548057e-06 -1 1.550444e-06 -1
+ 1.550469e-06 1 1.553659e-06 1 1.553684e-06 -1 1.555266e-06 -1 1.555291e-06 1 1.556070e-06 1
+ 1.556095e-06 -1 1.558481e-06 -1 1.558506e-06 1 1.559285e-06 1 1.559310e-06 -1 1.560089e-06 -1
+ 1.560114e-06 1 1.561696e-06 1 1.561721e-06 -1 1.563304e-06 -1 1.563329e-06 1 1.565715e-06 1
+ 1.565740e-06 -1 1.566519e-06 -1 1.566544e-06 1 1.567323e-06 1 1.567348e-06 -1 1.568126e-06 -1
+ 1.568151e-06 1 1.568930e-06 1 1.568955e-06 -1 1.570538e-06 -1 1.570563e-06 1 1.574556e-06 1
+ 1.574581e-06 -1 1.575360e-06 -1 1.575385e-06 1 1.576164e-06 1 1.576189e-06 -1 1.579379e-06 -1
+ 1.579404e-06 1 1.581790e-06 1 1.581815e-06 -1 1.584201e-06 -1 1.584226e-06 1 1.585005e-06 1
+ 1.585030e-06 -1 1.586613e-06 -1 1.586638e-06 1 1.587416e-06 1 1.587441e-06 -1 1.589024e-06 -1
+ 1.589049e-06 1 1.590631e-06 1 1.590656e-06 -1 1.591435e-06 -1 1.591460e-06 1 1.593043e-06 1
+ 1.593068e-06 -1 1.593846e-06 -1 1.593871e-06 1 1.594650e-06 1 1.594675e-06 -1 1.595454e-06 -1
+ 1.595479e-06 1 1.597061e-06 1 1.597086e-06 -1 1.597865e-06 -1 1.597890e-06 1 1.601080e-06 1
+ 1.601105e-06 -1 1.601884e-06 -1 1.601909e-06 1 1.603492e-06 1 1.603517e-06 -1 1.605903e-06 -1
+ 1.605928e-06 1 1.607510e-06 1 1.607535e-06 -1 1.608314e-06 -1 1.608339e-06 1 1.609118e-06 1
+ 1.609143e-06 -1 1.610725e-06 -1 1.610750e-06 1 1.611529e-06 1 1.611554e-06 -1 1.612333e-06 -1
+ 1.612358e-06 1 1.614744e-06 1 1.614769e-06 -1 1.615548e-06 -1 1.615573e-06 1 1.617959e-06 1
+ 1.617984e-06 -1 1.619567e-06 -1 1.619592e-06 1 1.621174e-06 1 1.621199e-06 -1 1.622782e-06 -1
+ 1.622807e-06 1 1.623585e-06 1 1.623610e-06 -1 1.624389e-06 -1 1.624414e-06 1 1.625193e-06 1
+ 1.625218e-06 -1 1.625997e-06 -1 1.626022e-06 1 1.626800e-06 1 1.626825e-06 -1 1.627604e-06 -1
+ 1.627629e-06 1
+ )
Ed dp dp1 dp0 0 0.5
Ed2 dp1 0 vb 0 1
En dn dn1 dp0 0 -0.5
En2 dn1 0 vb 0 1
Vb vb 0 2.3
Xm1 ldk dp me q
Xm2 dumm dn me q
Rdm v5 dumm 25
* BEN steering (LVTTL through dividers, on 1.65 V / off 1.25 V against 1.45 V)
Vben ben 0 PULSE(0 3.3 2n 1n 1n 1.2u 3u)
Ra ben bon 1k
Rb v33 bon 320
Rc bon 0 242
Rr1 v33 bref 300
Rr2 bref 0 240
Xs1 me bon mt q
Xs2 dums bref mt q
Rds v5 dums 25
Xb1 bc bon bt q
Rbs bc ldk 10
Xb2 dumb bref bt q
Rdb v5 dumb 25
* tails: op-amp regulated current sinks (ideal loop), emitter 10 ohm
Xmt mt mtb mte q
Rme mte 0 10
Bmt mtx 0 V=max(0,min(3.3,1000*({imod*10}-v(mte))))
Rmt mtx mtb 100
Cmt mtb 0 1n
Xbt bt btb bte q
Rbe bte 0 10
Bbt btx 0 V=max(0,min(3.3,1000*({ibias*10}-v(bte))))
Rbt btx btb 100
Cbt btb 0 1n
.tran 5p 3.3u 0 5p
.control
run
let il = -i(V5)
meas tran ion  when i(Lla)=30m rise=1
meas tran ben_on when v(ben)=1.65 rise=1
let lon = ion - ben_on
meas tran ioff when i(Lla)=10m fall=last
meas tran ben_off when v(ben)=1.65 fall=1
let loff = ioff - ben_off
print lon loff
meas tran vce_min_m1 min v(ldk)
meas tran vme max v(me)
meas tran vmt min v(mt)
meas tran vbt min v(bt)
meas tran ilmax max i(Lla) from=100n to=1.1u
meas tran ilmin min i(Lla) from=100n to=1.1u
wrdata laser.txt i(Lla) v(ben) v(bc) v(me) v(ldk) v(la) v(lk) v(mt) v(bt)
.endc
.end
